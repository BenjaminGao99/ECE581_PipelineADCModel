ADE simulation setup
Run mode: Single Run, Sweeps and Corners
Tests:
  ECE581_PipelineADCModel_MDAC_MUX_testbench_1: ECE581_PipelineADCModel/MDAC_MUX_testbench/schematic, simulator spectre
