ADE simulation setup
Test ECE581_PipelineADCModel_MDAC_MUX_testbench_1: ECE581_PipelineADCModel/MDAC_MUX_testbench/schematic, simulator spectre
  Models: /class/ece581/models/models_ece581
  Temperature: 27
  Analysis dc: (saves the operating point)
Run mode: Single Run, Sweeps and Corners
