ADE simulation setup
Run mode: Single Run, Sweeps and Corners
Tests:
  ECE581_PipelineADCModel_real1.5_ADC_ramp_1: ECE581_PipelineADCModel/real1.5_ADC_ramp/schematic, simulator spectre
    Outputs: VT("/Dout<0>"); VT("/Dout<1>")
