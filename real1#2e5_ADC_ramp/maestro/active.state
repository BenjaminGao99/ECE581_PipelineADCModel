ADE simulation setup
Test ECE581_PipelineADCModel_real1.5_ADC_ramp_1: ECE581_PipelineADCModel/real1.5_ADC_ramp/schematic, simulator spectre
  Models: /class/ece581/models/models_ece581
  Temperature: 27
  Analysis dc: (saves the operating point)
  Analysis tran: stop=11000n
  Output (VT("/voutp") - VT("/voutn"))
  Output (VT("/vinp") - VT("/vinn"))
  Output VT("/clk1")
  Output VT("/clk2")
  Output VT("/net7<0>") (unticked)
  Output VT("/net7<1>") (unticked)
  Output (VT("/I0/net13") - VT("/I0/net14"))
  Signals: /voutp, /voutn, /vinp, /vinn, /clk1, /clk2, /net7<0>, /net7<1>, /I0/net13, /I0/net14
Run mode: Single Run, Sweeps and Corners
