ADE simulation setup
Test ECE581_PipelineADCModel_real1.5_ADC_ramp_1: ECE581_PipelineADCModel/real1.5_ADC_ramp/schematic, simulator spectre
  Models: /class/ece581/models/models_ece581
  Temperature: 27
  Analysis dc: (saves the operating point)
  Output (VT("/voutp") - VT("/voutn"))
  Output (VT("/vinp") - VT("/vinn"))
  Output VT("/clk1")
  Output VT("/clk2")
  Output VT("/Dout<0>")
  Output VT("/Dout<1>")
  Output (VT("/I0/net13") - VT("/I0/net14"))
  Signals: /voutp, /voutn, /vinp, /vinn, /clk1, /clk2, /I0/net13, /I0/net14
Run mode: Single Run, Sweeps and Corners
