ADE simulation setup
Run mode: Single Run, Sweeps and Corners
Tests:
  ECE581_PipelineADCModel_testbench_diff_1: ECE581_PipelineADCModel/testbench_diff/schematic, simulator spectre
    Outputs: phase((VF("/Vout+") - VF("/Vout-"))); dB20((VF("/Vout+") - VF("/Vout-"))); (phase(VF("/I0/Vfb")) + 180); dB20(VF("/I0/Vfb")); (phase((VF("/Vout+") - VF("/Vout-"))) + 180); (VT("/net18") - VT("/net12"))
