ADE simulation setup
Run mode: Single Run, Sweeps and Corners
Tests:
  ECE581_PipelineADCModel_testbench_diff_1: ECE581_PipelineADCModel/testbench_diff/schematic, simulator spectre
