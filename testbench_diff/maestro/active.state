ADE simulation setup
Test ECE581_PipelineADCModel_testbench_diff_1: ECE581_PipelineADCModel/testbench_diff/schematic, simulator spectre
  Models: /class/ece581/models/models_ece581
  Temperature: 27
  Analysis ac: start=1 stop=1G
  Analysis dc: (saves the operating point)
  Output VF("/net18") (unticked)
  Output (VF("/net18") - VF("/net15")) (unticked)
  Output VF("/Vout+") (unticked)
  Output (VF("/Vout+") - VF("/Vout-")) (unticked)
  Output Loop Gain Phase = phaseDegUnwrapped(getData("loopGain" ?result "stb")) (unticked)
  Output Loop Gain dB20 = db(mag(getData("loopGain" ?result "stb"))) (unticked)
  Output (phase(VF("/I0/Vfb")) + 180) (unticked)
  Output dB20(VF("/I0/Vfb")) (unticked)
  Output dB20((VF("/Vout+") - VF("/Vout-"))) (unticked)
  Output phase((VF("/Vout+") - VF("/Vout-"))) (unticked)
  Signals: /net18, /net15, /Vout+, /Vout-, /I0/Vfb
Run mode: Single Run, Sweeps and Corners
