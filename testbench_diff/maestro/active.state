ADE simulation setup
Test ECE581_PipelineADCModel_testbench_diff_1: ECE581_PipelineADCModel/testbench_diff/schematic, simulator spectre
  Models: /class/ece581/models/models_ece581
  Temperature: 27
  Analysis dc: (saves the operating point)
  Analysis tran: stop=400u errpreset=conservative outputstart=2u
  Output VF("/net18") (unticked)
  Output (VF("/net18") - VF("/net15")) (unticked)
  Output VF("/Vout+") (unticked)
  Output (VF("/Vout+") - VF("/Vout-")) (unticked)
  Output Loop Gain Phase = phaseDegUnwrapped(getData("loopGain" ?result "stb")) (unticked)
  Output Loop Gain dB20 = db(mag(getData("loopGain" ?result "stb"))) (unticked)
  Output (phase(VF("/I0/Vfb")) + 180) (unticked)
  Output dB20(VF("/I0/Vfb")) (unticked)
  Output dB20((VF("/Vout+") - VF("/Vout-"))) (unticked)
  Output (phase((VF("/Vout+") - VF("/Vout-"))) + 180) (unticked)
  Output (VT("/net18") - VT("/net12"))
  Output (VT("/Vout+") - VT("/Vout-"))
  Output output noise; V**2 / Hz = (getData("out" ?result "noise")**2) (unticked)
  Signals: /Vout+, /Vout-, /I0/Vfb, /net14, /net12
Run mode: Single Run, Sweeps and Corners
