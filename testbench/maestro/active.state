ADE simulation setup
Test HW4_amp_testbench_1: HW4_amp/testbench/schematic, simulator spectre
  Models: /class/ece581/models/models_ece581
  Temperature: 27
  Analysis stb: start=1 stop=100M probe=/IPRB0 stbProbeMode=single-ended
  Analysis dc: (saves the operating point)
  Output Loop Gain Phase = phaseDegUnwrapped(getData("loopGain" ?result "stb"))
  Output Loop Gain dB20 = db(mag(getData("loopGain" ?result "stb")))
Run mode: Single Run, Sweeps and Corners
