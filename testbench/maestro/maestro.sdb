ADE simulation setup
Run mode: Single Run, Sweeps and Corners
Tests:
  HW4_amp_testbench_1: HW4_amp/testbench/schematic, simulator spectre
