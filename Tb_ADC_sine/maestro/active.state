ADE simulation setup
Test ECE581_PipelineADCModel_Tb_ADC_sine_1: ECE581_PipelineADCModel/Tb_ADC_sine/schematic, simulator spectre
  Temperature: 27
  Simulator options: reltol=1e-4 vabstol=1e-7 tnom=25
  Analysis dc: (saves the operating point)
  Analysis tran: stop=5u errpreset=conservative strobeperiod=40n
  Output "VT(\"/vinp\") - VT(\"/vinn\")" = (VT("/vinp") - VT("/vinn"))
  Output "VT(\"/DOut\")" = VT("/DOut")
  Output "VT(\"/clk1\")" = v("/clk1" ?result "tran")
  Output "VT(\"/clk2\")" = v("/clk2" ?result "tran")
  Output v /vinn; tran (V) = vtime('tran "/vinn")
  Output v /vinp; tran (V) = vtime('tran "/vinp")
