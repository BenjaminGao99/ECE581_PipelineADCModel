ADE simulation setup
Test ECE581_PiplelineADCModel_Tb_ADC_sine_1: ECE581_PiplelineADCModel/Tb_ADC_sine/schematic, simulator spectre
  Temperature: 27
Run mode: Single Run, Sweeps and Corners
