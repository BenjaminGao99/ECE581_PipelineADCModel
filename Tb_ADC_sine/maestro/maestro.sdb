ADE simulation setup
Run mode: Single Run, Sweeps and Corners
Tests:
  ECE581_PiplelineADCModel_Tb_ADC_sine_1: ECE581_PiplelineADCModel/Tb_ADC_sine/schematic, simulator spectre
