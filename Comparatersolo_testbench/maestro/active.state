ADE simulation setup
Test ECE581_PipelineADCModel_Comparatersolo_testbench_1: ECE581_PipelineADCModel/Comparatersolo_testbench/schematic, simulator spectre
  Models: /class/ece581/models/models_ece581
  Temperature: 27
  Analysis dc: (saves the operating point)
  Analysis tran: stop=1500n
  Output VT("/CLK")
  Output VT("/I0/Y")
  Output VT("/I0/X")
  Output VT("/sigref")
  Output VT("/sigin")
  Output VT("/sigout+")
  Signals: /CLK, /I0/Y, /I0/X, /sigref, /sigin, /sigout+
Run mode: Single Run, Sweeps and Corners
