ADE simulation setup
Run mode: Single Run, Sweeps and Corners
Tests:
  ECE581_PipelineADCModel_Comparatersolo_testbench_1: ECE581_PipelineADCModel/Comparatersolo_testbench/schematic, simulator spectre
    Outputs: (VT("/sigin") - VT("/sigref"))
