ADE simulation setup
Run mode: Single Run, Sweeps and Corners
Tests:
  ECE581_PipelineADCModel_Tb_ADC_ramp_1: ECE581_PipelineADCModel/Tb_ADC_ramp/schematic, simulator spectre
