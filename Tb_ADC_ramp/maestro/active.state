ADE simulation setup
Test ECE581_PipelineADCModel_Tb_ADC_ramp_1: ECE581_PipelineADCModel/Tb_ADC_ramp/schematic, simulator spectre
  Temperature: 27
  Simulator options: reltol=1e-4 vabstol=1e-7
  Analysis tran: stop=1.63862m errpreset=moderate strobeperiod=40n method=trap outputstart=220n
  Signals: /DOut as Dout
Run mode: Single Run, Sweeps and Corners
