ADE simulation setup
Test ECE581_PipelineADCModel_Tb_ADC_ramp_1: ECE581_PipelineADCModel/Tb_ADC_ramp/schematic, simulator spectre
  Models: /class/ece581/models/models_ece581
  Temperature: 27
  Analysis tran: stop=1.63862m errpreset=moderate outputstart=220n
  Output (VT("/vinp") - VT("/vinn"))
  Output VT("/clk2") (unticked)
  Output VT("/clk1") (unticked)
  Output VT("/DOut")
  Signals: /vinp, /vinn, /clk2, /clk1, /DOut
Run mode: Single Run, Sweeps and Corners
