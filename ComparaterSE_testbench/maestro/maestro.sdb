ADE simulation setup
Run mode: Single Run, Sweeps and Corners
Tests:
  ECE581_PipelineADCModel_ComparaterSE_testbench_1: ECE581_PipelineADCModel/ComparaterSE_testbench/schematic, simulator spectre
    Outputs: sigout+; sigin; CLK; X; Y; sigout-; sigout_ideal
