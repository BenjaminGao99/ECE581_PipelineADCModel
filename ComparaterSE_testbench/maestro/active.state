ADE simulation setup
Test ECE581_PipelineADCModel_ComparaterSE_testbench_1: ECE581_PipelineADCModel/ComparaterSE_testbench/schematic, simulator spectre
  Models: /class/ece581/models/models_ece581
  Temperature: 27
  Analysis tran: stop=1500n
  Signals: /sigout+ as sigout+, /sigin as sigin, /CLK as CLK, /I0/X as X, /I0/Y as Y, /sigout- as sigout-, /sigout_ideal as sigout_ideal
Run mode: Single Run, Sweeps and Corners
