ADE simulation setup
Test ECE581_PipelineADCModel_ComparaterSE_testbench_1: ECE581_PipelineADCModel/ComparaterSE_testbench/schematic, simulator spectre
  Models: /class/ece581/models/models_ece581
  Temperature: 27
  Analysis tran: stop=1500n
  Output i /I3/N0/D; dc (I) = i("/I3/N0/D" ?result "dc") (unticked)
  Output i /I3/N3/D; dc (I) = i("/I3/N3/D" ?result "dc") (unticked)
  Output v /net11; dc (V) = v("/net11" ?result "dc") (unticked)
  Output v /net10; dc (V) = v("/net10" ?result "dc") (unticked)
  Output V1out = (VS("/net11") - VS("/net10")) (unticked)
  Output V0out = (VS("/net13") - VS("/net12")) (unticked)
  Output VT("/sigout+")
  Output VT("/sigout0")
  Output VT("/Vinp")
  Output VT("/Vinn")
  Output VT("/CLK")
  Output (VT("/Vinp") - VT("/Vinn"))
  Signals: /net11, /net10, /net13, /net12, /sigout0, /Vinp, /Vinn, /CLK
Run mode: Single Run, Sweeps and Corners
