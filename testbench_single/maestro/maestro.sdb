ADE simulation setup
Run mode: Single Run, Sweeps and Corners
Tests:
  HW1_testbench_1: HW4/testbench/schematic, simulator spectre
    Outputs: Vout; v /Vin-; tran (V); v /Ideal; tran (V)
