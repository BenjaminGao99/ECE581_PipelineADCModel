ADE simulation setup
Test HW1_testbench_1: HW4/testbench/schematic, simulator spectre
  Models: /class/ece581/models/models_ece581
  Temperature: 27
  Analysis dc: (saves the operating point)
  Analysis tran: stop=5u
  Output Loop Gain Phase = phaseDegUnwrapped(getData("loopGain" ?result "stb")) (unticked)
  Output Loop Gain dB20 = db(mag(getData("loopGain" ?result "stb"))) (unticked)
  Output v /Vout; dc (V) = v("/Vout" ?result nil) (unticked)
  Output v /Vout; ac mag(V) = vfreq('ac "/Vout") (unticked)
  Output v /Vin-; tran (V) = vtime('tran "/Vin-")
  Output v /Vin; tran (V) = vtime('tran "/Vin")
  Output v /Vout; tran (V) = vtime('tran "/Vout")
  Output v /Ideal; tran (V) = vtime('tran "/Ideal")
Run mode: Single Run, Sweeps and Corners
